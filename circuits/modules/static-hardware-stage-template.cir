* CALCOTONE reusable hardware-stage behavioral calibration
* The expression is filled from the same typed operating point used by realtime DSP.
* ngspice 42 B-sources use ternary conditionals; keep legacy generated if(a,b,c) expressions portable through this local helper.

.func if(x,y,z) {x ? y : z}

Vin in 0 SIN(0 {{INPUT_AMPLITUDE}} {{INPUT_FREQUENCY}})
Bstage out 0 V = {{TRANSFER_EXPRESSION}}
Rload out 0 10k

.tran {{OUTPUT_STEP}} {{STOP_TIME}} {{START_TIME}} {{MAX_STEP}}

.control
set wr_singlescale
set wr_vecnames
run
wrdata {{OUTPUT_PATH}} v(out)
quit
.endc

.end
