* CALCOTONE reusable hardware-stage behavioral calibration
* The expression is filled from the same typed operating point used by realtime DSP.
* The control block must run the transient before exporting v(out); wr_singlescale writes time first.

Vin in 0 SIN(0 {{INPUT_AMPLITUDE}} {{INPUT_FREQUENCY}})
Bstage out 0 V = {{TRANSFER_EXPRESSION}}
Rload out 0 10k

.tran {{OUTPUT_STEP}} {{STOP_TIME}} {{START_TIME}} {{MAX_STEP}}

.control
set wr_singlescale
set wr_vecnames
run
wrdata {{OUTPUT_PATH}} v(out)
quit
.endc

.end
